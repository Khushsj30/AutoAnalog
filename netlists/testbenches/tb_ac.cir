.TITLE AutoAnalog Two-Stage CMOS Op-Amp — AC Analysis

.INCLUDE 'models/tsmc180nm_tt.lib'
.INCLUDE 'netlists/subcircuits/opamp_2stage.cir'

VDD    VDD    0    DC 1.8
VBIAS  VBIAS  0    DC 0.57
VIN    INP    0    DC 0.9  AC 1.0
VINN   INN    0    DC 0.9
RFEEDBACK  OUT  INN  1G
CL     OUT    0    10P
RL     OUT    0    100K

XOPA   INP   INN   OUT   VDD   0   VBIAS   OPAMP_2STAGE

.OP
.AC DEC 100 1 1G
.PRINT AC VDB(OUT) VP(OUT)
.OPTIONS NUMDGT=6 NOMOD
.END
